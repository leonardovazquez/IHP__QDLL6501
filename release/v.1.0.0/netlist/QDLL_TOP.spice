** sch_path: /home/designer/designs/libs/Cells/QDLL_TOP.sch
.subckt QDLL_TOP VDD VSS IN1 OUT1 OUT2 IN2 CPOUT2 VCONT2 IN3 OUT3
*.PININFO VDD:B VSS:B IN1:I IN2:I OUT1:O OUT2:O CPOUT2:O VCONT2:I OUT3:O IN3:I
x1 VDD OUT1 IN1 VSS net1 net1 SE_QDLL
x2 VDD OUT2 IN2 VSS CPOUT2 VCONT2 SE_QDLL
x3 VSS VDD IN3 OUT3 DLine
.ends

* expanding   symbol:  Cells/SE_QDLL.sym # of pins=6
** sym_path: /home/designer/designs/libs/Cells/SE_QDLL.sym
** sch_path: /home/designer/designs/libs/Cells/SE_QDLL.sch
.subckt SE_QDLL VDD VOUT VIN VSS CP VCONT
*.PININFO VDD:B VOUT:O VIN:I VSS:B CP:O VCONT:I
x1 VSS VDD net1 VOUT DLine
x2 VDD VIN net1 VCONT VSS VCDL
x3 net2 CP VSS CP
x4 VDD VSS VIN net2 VOUT PD
.ends

* expanding   symbol:  Cells/DLine.sym # of pins=4
** sym_path: /home/designer/designs/libs/Cells/DLine.sym
** sch_path: /home/designer/designs/libs/Cells/DLine.sch
.subckt DLine VSS VDD VIN VOUT
*.PININFO VOUT:O VIN:I VDD:B VSS:B
x2 net1 net4 VDD VSS sg13g2_inv_4
x3 net2 net1 VDD VSS sg13g2_inv_8
x4 VOUT net2 VDD VSS sg13g2_inv_16
x5 net3 VIN VDD VSS sg13g2_dlygate4sd3_1
x6 net4 net3 VDD VSS sg13g2_dlygate4sd2_1
.ends

* expanding   symbol:  Cells/VCDL.sym # of pins=5
** sym_path: /home/designer/designs/libs/Cells/VCDL.sym
** sch_path: /home/designer/designs/libs/Cells/VCDL.sch
.subckt VCDL VDD VIN VOUT VCONT VSS
*.PININFO VDD:B VSS:B VIN:I VCONT:I VOUT:O
MM1 VOUT VIN net3 VSS sg13_lv_nmos w=2u l=0.13u ng=1 m=1
MM2 net3 VCONT VSS VSS sg13_lv_nmos w=3.5u l=0.18u ng=1 m=1
MM3 net1 VCONT VSS VSS sg13_lv_nmos w=2u l=0.25u ng=1 m=1
MM4 VOUT VIN net2 VDD sg13_lv_pmos w=4.46u l=0.13u ng=1 m=1
MM5 net2 net1 VDD VDD sg13_lv_pmos w=2.24u l=0.13u ng=1 m=1
MM6 net1 net1 VDD VDD sg13_lv_pmos w=2.24u l=0.13u ng=1 m=1
.ends

* expanding   symbol:  Cells/CP.sym # of pins=3
** sym_path: /home/designer/designs/libs/Cells/CP.sym
** sch_path: /home/designer/designs/libs/Cells/CP.sch
.subckt CP CPIN CPOUT VSS
*.PININFO VSS:B CPIN:I CPOUT:O
CC1 CPOUT VSS cap_cmim w=60e-6 l=20e-6 m=1
x1 CPOUT CPIN RES
.ends

* expanding   symbol:  Cells/PD.sym # of pins=5
** sym_path: /home/designer/designs/libs/Cells/PD.sym
** sch_path: /home/designer/designs/libs/Cells/PD.sch
.subckt PD VDD VSS PDIN1 PDOUT PDIN2
*.PININFO VDD:B VSS:B PDOUT:O PDIN1:I PDIN2:I
x1 PDOUT PDIN1 PDIN2 VDD VSS sg13g2_xor2_1
.ends

* expanding   symbol:  Cells/RES.sym # of pins=2
** sym_path: /home/designer/designs/libs/Cells/RES.sym
** sch_path: /home/designer/designs/libs/Cells/RES.sch
.subckt RES ROUT RIN
*.PININFO RIN:I ROUT:O
RR13 net1 RIN -72 $SUB=VSS $[rppd] w=1e-6 l=10e-6 b=0 m=1
RR1 net2 net1 -72 $SUB=VSS $[rppd] w=1e-6 l=10e-6 b=0 m=1
RR2 net3 net2 -72 $SUB=VSS $[rppd] w=1e-6 l=10e-6 b=0 m=1
RR3 net4 net3 -72 $SUB=VSS $[rppd] w=1e-6 l=10e-6 b=0 m=1
RR4 net5 net4 -72 $SUB=VSS $[rppd] w=1e-6 l=10e-6 b=0 m=1
RR5 net6 net5 -72 $SUB=VSS $[rppd] w=1e-6 l=10e-6 b=0 m=1
RR6 net7 net6 -72 $SUB=VSS $[rppd] w=1e-6 l=10e-6 b=0 m=1
RR7 net8 net7 -72 $SUB=VSS $[rppd] w=1e-6 l=10e-6 b=0 m=1
RR8 net9 net8 -72 $SUB=VSS $[rppd] w=1e-6 l=10e-6 b=0 m=1
RR9 net10 net9 -72 $SUB=VSS $[rppd] w=1e-6 l=10e-6 b=0 m=1
RR10 net11 net10 -72 $SUB=VSS $[rppd] w=1e-6 l=10e-6 b=0 m=1
RR11 ROUT net11 -72 $SUB=VSS $[rppd] w=1e-6 l=10e-6 b=0 m=1
.ends
