** sch_path: /home/designer/shared/2026/Cells/RES.sch
.subckt RES ROUT RIN
*.PININFO RIN:I ROUT:O
R1 net1 RIN  rppd w=1e-6 l=10e-6 m=1 b=0
R3 net2 net1 rppd w=1e-6 l=10e-6 m=1 b=0
R4 net3 net2 rppd w=1e-6 l=10e-6 m=1 b=0
R5 net4 net3  rppd w=1e-6 l=10e-6 m=1 b=0
R2 net5 net4  rppd w=1e-6 l=10e-6 m=1 b=0
R6 net6 net5  rppd w=1e-6 l=10e-6 m=1 b=0
R7 net7 net6  rppd w=1e-6 l=10e-6 m=1 b=0
R8 net8 net7  rppd w=1e-6 l=10e-6 m=1 b=0
R9 net9 net8  rppd w=1e-6 l=10e-6 m=1 b=0
R10 net10 net9  rppd w=1e-6 l=10e-6 m=1 b=0
R11 net11 net10  rppd w=1e-6 l=10e-6 m=1 b=0
R12 ROUT net11  rppd w=1e-6 l=10e-6 m=1 b=0
.ends
