** sch_path: /home/designer/shared/2026/Cells/DLine.sch
.subckt DLINEW VSS VDD VIN VOUT
*.PININFO VOUT:O VIN:I VDD:B VSS:B
x2 net1 net4 VDD VSS sg13g2_inv_4
x3 net2 net1 VDD VSS sg13g2_inv_8
x4 VOUT net2 VDD VSS sg13g2_inv_16
x5 net3 VIN VDD VSS sg13g2_dlygate4sd3_1
x6 net4 net3 VDD VSS sg13g2_dlygate4sd2_1
.ends
