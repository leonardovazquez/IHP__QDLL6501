** sch_path: /foss/designs/UCU/uniccass-icdesign-tools/shared_xserver/QDLL/Cells/QDLL.sch
.subckt QDLL VDD VSS IN1 OUT1 OUT2 IN2
*.PININFO VDD:B VSS:B IN1:I OUT1:O IN2:I OUT2:O
x1 VDD IN1 net1 net2 VSS VCDL
x2 VSS VDD net1 OUT1 DLine
x3 VDD VSS IN1 net6 OUT1 PD
x4 VDD VSS IN2 net5 OUT2 PD
x5 VDD IN2 net3 net4 VSS VCDL
x6 VSS VDD net3 OUT2 DLine
x7 net6 net2 VSS CP
x8 net5 net4 VSS CP
.ends

* expanding   symbol:  /foss/designs/UCU/uniccass-icdesign-tools/shared_xserver/QDLL/Cells/VCDL.sym # of pins=5
** sym_path: /foss/designs/UCU/uniccass-icdesign-tools/shared_xserver/QDLL/Cells/VCDL.sym
** sch_path: /foss/designs/UCU/uniccass-icdesign-tools/shared_xserver/QDLL/Cells/VCDL.sch
.subckt VCDL VDD VIN VOUT VCONT VSS
*.PININFO VDD:B VSS:B VIN:I VCONT:I VOUT:O
M1 VOUT VIN net3 VSS sg13_lv_nmos w=2u l=0.13u ng=1
M2 net3 VCONT VSS VSS sg13_lv_nmos w=3.5u l=0.18u ng=1
M3 net1 VCONT VSS VSS sg13_lv_nmos w=2u l=0.25u ng=1
M4 VOUT VIN net2 VDD sg13_lv_pmos w=4.46u l=0.13u ng=1
M5 net2 net1 VDD VDD sg13_lv_pmos w=2.24u l=0.13u ng=1
M6 net1 net1 VDD VDD sg13_lv_pmos w=2.24u l=0.13u ng=1
.ends

* expanding   symbol:  /foss/designs/UCU/uniccass-icdesign-tools/shared_xserver/QDLL/Cells/DLine.sym # of pins=4
** sym_path: /foss/designs/UCU/uniccass-icdesign-tools/shared_xserver/QDLL/Cells/DLine.sym
** sch_path: /foss/designs/UCU/uniccass-icdesign-tools/shared_xserver/QDLL/Cells/DLine.sch
.subckt DLine VSS VDD VIN VOUT
*.PININFO VOUT:O VIN:I VDD:B VSS:B
x2 net1 net4 VDD VSS sg13g2_inv_4
x3 net2 net1 VDD VSS sg13g2_inv_8
x4 VOUT net2 VDD VSS sg13g2_inv_16
x5 net3 VIN VDD VSS sg13g2_dlygate4sd3_1
x6 net4 net3 VDD VSS sg13g2_dlygate4sd2_1
.ends

* expanding   symbol:  /foss/designs/UCU/uniccass-icdesign-tools/shared_xserver/QDLL/Cells/PD.sym # of pins=5
** sym_path: /foss/designs/UCU/uniccass-icdesign-tools/shared_xserver/QDLL/Cells/PD.sym
** sch_path: /foss/designs/UCU/uniccass-icdesign-tools/shared_xserver/QDLL/Cells/PD.sch
.subckt PD VDD VSS PDIN1 PDOUT PDIN2
*.PININFO VDD:B VSS:B PDOUT:O PDIN1:I PDIN2:I
x1 PDOUT PDIN1 PDIN2 VDD VSS sg13g2_xor2_1
.ends

* expanding   symbol:  /foss/designs/UCU/uniccass-icdesign-tools/shared_xserver/QDLL/Cells/CP.sym # of pins=3
** sym_path: /foss/designs/UCU/uniccass-icdesign-tools/shared_xserver/QDLL/Cells/CP.sym
** sch_path: /foss/designs/UCU/uniccass-icdesign-tools/shared_xserver/QDLL/Cells/CP.sch
.subckt CP CPIN CPOUT VSS
*.PININFO VSS:B CPIN:I CPOUT:O
C1 CPOUT VSS cap_cmim w=60e-6 l=20e-6
x1 CPOUT CPIN RES
.ends

* expanding   symbol:  /foss/designs/UCU/uniccass-icdesign-tools/shared_xserver/QDLL/Cells/RES.sym # of pins=2
** sym_path: /foss/designs/UCU/uniccass-icdesign-tools/shared_xserver/QDLL/Cells/RES.sym
** sch_path: /foss/designs/UCU/uniccass-icdesign-tools/shared_xserver/QDLL/Cells/RES.sch
.subckt RES ROUT RIN
*.PININFO RIN:I ROUT:O
R13 net1 RIN rppd w=1e-6 l=10e-6 m=1 b=0
R1 net2 net1 rppd w=1e-6 l=10e-6 m=1 b=0
R2 net3 net2 rppd w=1e-6 l=10e-6 m=1 b=0
R3 net4 net3 rppd w=1e-6 l=10e-6 m=1 b=0
R4 net5 net4 rppd w=1e-6 l=10e-6 m=1 b=0
R5 net6 net5 rppd w=1e-6 l=10e-6 m=1 b=0
R6 net7 net6 rppd w=1e-6 l=10e-6 m=1 b=0
R7 net8 net7 rppd w=1e-6 l=10e-6 m=1 b=0
R8 net9 net8 rppd w=1e-6 l=10e-6 m=1 b=0
R9 net10 net9 rppd w=1e-6 l=10e-6 m=1 b=0
R10 net11 net10 rppd w=1e-6 l=10e-6 m=1 b=0
R11 ROUT net11 rppd w=1e-6 l=10e-6 m=1 b=0
.ends
